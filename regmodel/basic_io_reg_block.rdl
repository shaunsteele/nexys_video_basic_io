addrmap basic_io_reg_block {
    name = "Nexys Video Basic IO Controller";
    desc = "Register description of the Digilent Nexys Video development board's buttons, switches, and LED controller";

    default regwidth = 64;

    reg {
        name = "Basic IO Register";
        
        // field {
        //     desc = "Reserved";
        //     hw = na;
        //     sw = r;
        // } RSVD[63:21] = 0;

        field {
            desc = "Button Up";
            hw = w;
            sw = r;
        } BTNU[20:20] = 0;

        field {
            desc = "Button Left";
            hw = w;
            sw = r;
        } BTNL[19:19] = 0;

        field {
            desc = "Button Center";
            hw = w;
            sw = r;
        } BTNC[18:18] = 0;

        field {
            desc = "Button Right";
            hw = w;
            sw = r;
        } BTNR[17:17] = 0;

        field {
            desc = "Button Down";
            hw = w;
            sw = r;
        } BTND[16:16] = 0;

        field {
            desc = "Switches";
            hw = w;
            sw = r;
        } SW[15:8] = 0;

        field {
            desc = "LEDs";
            hw = r;
            sw = rw;
        } LD[7:0] = 0;
    } BASIC_IO_REG @ 0x00;
};
